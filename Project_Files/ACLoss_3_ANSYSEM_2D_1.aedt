# Ansys Electronics Desktop project, version 2022.1
materials:
  vacuum: permittivity=1
  Copper (Annealed)_40C: conductivity=53777712
  N42UH: thermal_modifier{Property=permeability free_form_value="1 - 0.0012*(Temp - 20)"} thermal_modifier{Property=magnetic_coercivity free_form_value="1 - 0.00465*(Temp - 20)"} permeability{BTypeForSingleCurve=intrinsic HUnit=A_per_meter BUnit=tesla curve (-1990000, 0) (-1989534.1, 0.032694171) (-1989057.3, 0.065221647) (-1988569.4, 0.097561906) (-1988070, 0.12969429) (-1987558.9, 0.16159807) (-1987035.9, 0.19325244) (-1986500.6, 0.22463661) (-1985952.8, 0.25572984) (-1985392.1, 0.28651145) (-1984818.4, 0.31696093) (-1984231.2, 0.34705794) (-1983630.2, 0.3767824) (-1983015.2, 0.40611451) (-1982385.8, 0.43503483) (-1981741.7, 0.46352433) (-1981082.4, 0.49156443) (-1980407.8, 0.51913707) (-1979717.3, 0.54622477) (-1979010.7, 0.57281066) (-1978287.6, 0.59887859) (-1977547.5, 0.62441312) (-1976790, 0.64939962) (-1976014.9, 0.67382429) (-1975221.6, 0.69767424) (-1974409.7, 0.72093752) (-1973578.8, 0.74360318) (-1972728.5, 0.76566128) (-1971858.3, 0.78710299) (-1970967.7, 0.80792058) (-1970056.2, 0.82810745) (-1969123.4, 0.8476582) (-1968168.8, 0.86656861) (-1967191.8, 0.8848357) (-1966191.9, 0.90245773) (-1965168.7, 0.91943419) (-1964121.4, 0.93576583) (-1963049.7, 0.95145466) (-1961952.9, 0.96650394) (-1960830.4, 0.98091816) (-1959681.6, 0.99470303) (-1958505.9, 1.0078655) (-1957302.7, 1.0204135) (-1956071.3, 1.0323564) (-1954811.1, 1.0437044) (-1953521.4, 1.054469) (-1952201.5, 1.0646623) (-1950850.7, 1.0742977) (-1949468.3, 1.0833893) (-1948053.5, 1.0919521) (-1946605.5, 1.1000018) (-1945123.7, 1.1075547) (-1943607.2, 1.1146278) (-1942055.2, 1.1212386) (-1940466.9, 1.1274049) (-1938841.4, 1.1331451) (-1937177.8, 1.1384776) (-1935475.2, 1.1434211) (-1933732.9, 1.1479944) (-1931949.7, 1.1522164) (-1930124.8, 1.1561058) (-1928257.1, 1.1596812) (-1926345.7, 1.1629611) (-1924389.6, 1.1659636) (-1922387.7, 1.1687066) (-1920338.9, 1.1712073) (-1918242.2, 1.1734828) (-1916096.3, 1.1755493) (-1913900.2, 1.1774229) (-1911652.7, 1.1791187) (-1909352.6, 1.1806514) (-1906998.7, 1.1820349) (-1904589.6, 1.1832824) (-1902124.2, 1.1844065) (-1899601, 1.1854192) (-1897018.7, 1.1863314) (-1894376, 1.1871537) (-1891671.4, 1.1878957) (-1888903.5, 1.1885665) (-1886070.8, 1.1891743) (-1883171.8, 1.1897269) (-1880204.9, 1.1902313) (-1877168.6, 1.1906939) (-1874061.2, 1.1911205) (-1870881, 1.1915164) (-1867626.4, 1.1918863) (-1864295.5, 1.1922346) (-1860886.7, 1.192565) (-1857398.1, 1.1928809) (-1853827.8, 1.1931853) (-1850174, 1.1934809) (-1846434.6, 1.19377) (-1842607.6, 1.1940545) (-1838691.1, 1.1943364) (-1834682.8, 1.1946172) (-1830580.7, 1.1948981) (-1826382.6, 1.1951804) (-1822086.2, 1.195465) (-1817689.2, 1.1957529) (-1813189.3, 1.1960447) (-1808584, 1.1963411) (-1803871, 1.1966427) (-1799047.5, 1.19695) (-1794111.2, 1.1972634) (-1789059.3, 1.1975832) (-1783889.1, 1.1979099) (-1778597.8, 1.1982437) (-1773182.7, 1.198585) (-1767640.8, 1.1989339) (-1761969.2, 1.1992909) (-1756164.8, 1.199656) (-1750224.5, 1.2000295) (-1744145.1, 1.2004117) (-1737923.4, 1.2008027) (-1731556.1, 1.2012029) (-1725039.7, 1.2016124) (-1718370.7, 1.2020315) (-1711545.6, 1.2024604) (-1704560.7, 1.2028993) (-1697412.3, 1.2033484)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} conductivity=230202.58 magnetic_coercivity{Magnitude=-992823.69A_per_meter DirComp1=1 DirComp2=0 DirComp3=0}
  M250-35A_20C: permeability{HUnit=A_per_meter BUnit=tesla curve (0, 0) (12, 0.1) (24, 0.2) (36, 0.3) (48, 0.4) (60, 0.5) (72, 0.6) (84, 0.7) (96, 0.8) (109, 0.9) (128, 1) (155, 1.1) (200, 1.2) (295, 1.3) (578, 1.4) (1567, 1.5) (3673, 1.6) (6996, 1.7) (13134.9088, 1.8162) (28200.2369, 1.8924) (100790, 1.998) (180370, 2.1) (259950, 2.2) (339530, 2.3) (419110, 2.4) (498690, 2.5)} conductivity=1694915.3 core_loss_type="Electrical Steel" core_loss_kh=187.425 core_loss_kc=0.34153292 mass_density=7650 stacking_type=Lamination stacking_factor=0.97 stacking_direction=V(3)
  Mild Steel_20C: permeability{HUnit=A_per_meter BUnit=tesla curve (0, 0) (117.9112, 0.1) (235.742, 0.2) (353.705, 0.3) (471.4946, 0.4) (589.464, 0.5) (707.3321, 0.6) (825, 0.7) (943.2034, 0.8) (1061, 0.9) (1179.5384, 1) (1299, 1.1) (1425, 1.2) (1565, 1.3) (1832.0513, 1.4) (2480.35, 1.5) (3326.2307, 1.6) (4500, 1.7) (5860, 1.8) (7600, 1.9) (11500, 2) (15479, 2.05) (25426, 2.1) (45320, 2.15) (124900, 2.25) (204470, 2.35) (284050, 2.45)} conductivity=6993007 core_loss_type="Electrical Steel" mass_density=7800 stacking_type=Lamination stacking_factor=0.97 stacking_direction=V(3)
  copper: permeability=0.999991 conductivity=58000000

design 01_Motor-CAD ACLoss_4 (Maxwell 2D, Transient, XY geometry, model units mm)
options: ModelDepth=Magnetic_Axial_Length SkewModelType=1 SkewPart=0 SkewAngle=5deg NumberOfSlices=3
variables:
  DiaGap = 175mm
  DiaStatorYoke = 250mm
  DiaShaft = 55mm
  DiaOuter = 250mm
  Airgap = 1mm
  StatorSkewAngle = 0deg
  Model_Length = 0mm
  Magnet_Length = 100mm
  Stator_Lam_Length = 0mm
  Rotor_Lam_Length = 0mm
  RotorDia = 173mm
  Rotor_Slices = 1
  SlotNumber_Stator = 48
  SlotType_Stator = 3
  Hs0_Stator = 1mm
  Hs1_Stator = 1.1478427mm
  Hs2_Stator = 21.757403mm
  Bs0_Stator = 2mm
  Bs1_Stator = 4.7358913mm
  Bs2_Stator = 7.5880024mm
  Rs_Stator = 1mm
  Magnetic_Axial_Length = 100mm
  Layers = 1
  ParallelPaths = 2
  WdgExt_F = 1mm
  SpanExt = 34.036392mm
  HalfAxial = 0
  SymmetryFactor = 8
  SegAngle = 0deg
  NumPoles = 8
  Magnet_Axial_Offset = 0mm
  Axial_Segments = 6
  Shaft_Hole_Diameter = 0mm
  Sleeve_Thickness = 0mm
  Banding_Thickness = 0mm
  IPeak = 353.55339A
  PhaseAdvance = 54.69deg
  MachineRPM = 6000rpm
  NumTorqueCycles = 1
  NumTorquePointsPerCycle = 120
  DriveOffsetED = 0deg
  InitialPositionMD = -DriveOffsetED / (NumPoles/2)
geometry:
  Rotor_1 [M250-35A_20C] = polyline(z=0mm, xy in mm: (63.77449, 58.438553) (60.45763, 60.45763) (35.355339, 35.355339) (39.828579, 30.227211) (43.564073, 24.539183) (29.561002, 18.738921) (27.320623, 21.876553) (24.748737, 24.748737) (19.445436, 19.445436) (25.406687, 10.523794) (27.5, 7.1054274e-15) (35, 0) (34.787657, 3.8495383) (34.153203, 7.6523667) (48.156275, 13.452629) (49.536924, 6.7891926) (50, -8.6409102e-11) (85.5, 0) (86.417671, 3.773077) (79.91558, 33.102117) (63.77449, 58.438553), closed, covered, AngularArc from point 2 over 3 centre=(0mm, 0mm, 0mm) angle=-15.607897deg plane=XY, AngularArc from point 5 over 3 centre=(0mm, 0mm, 0mm) angle=12.62911deg plane=XY, AngularArc from point 8 over 3 centre=(0mm, 0mm, 0mm) angle=-45deg plane=XY, AngularArc from point 11 over 3 centre=(0mm, 0mm, 0mm) angle=12.62911deg plane=XY, AngularArc from point 14 over 3 centre=(0mm, 0mm, 0mm) angle=-15.607897deg plane=XY, AngularArc from point 18 over 3 centre=(0mm, 0mm, 0mm) angle=40deg plane=XY)
  RotorAir [vacuum] = polyline(z=0mm, xy in mm: (63.77449, 58.438553) (62.484483, 59.815879) (61.164737, 61.164737) (60.45763, 60.45763) (63.77449, 58.438553), closed, covered, AngularArc from point 0 over 3 centre=(0mm, 0mm, 0mm) angle=2.5deg plane=XY)
  RotorDuctFluidRegion [vacuum] = polyline(z=0mm, xy in mm: (35.355339, 35.355339) (24.748737, 24.748737) (27.320623, 21.876553) (29.561002, 18.738921) (43.564073, 24.539183) (39.828579, 30.227211) (35.355339, 35.355339), closed, covered, AngularArc from point 1 over 3 centre=(0mm, 0mm, 0mm) angle=-12.62911deg plane=XY, AngularArc from point 4 over 3 centre=(0mm, 0mm, 0mm) angle=15.607897deg plane=XY)
  Shaft [Mild Steel_20C] = polyline(z=0mm, xy in mm: (19.445436, 19.445436) (0, 0) (27.5, 0) (25.406687, 10.523794) (19.445436, 19.445436), closed, covered, AngularArc from point 2 over 3 centre=(0mm, 0mm, 0mm) angle=45deg plane=XY)
  RotorDuctFluidRegion_1 [vacuum] = polyline(z=0mm, xy in mm: (35, -3.0834002e-11) (50, 0) (49.536924, 6.7891926) (48.156275, 13.452629) (34.153203, 7.6523667) (34.787657, 3.8495383) (35, -3.0834002e-11), closed, covered, AngularArc from point 1 over 3 centre=(0mm, 0mm, 0mm) angle=15.607897deg plane=XY, AngularArc from point 4 over 3 centre=(0mm, 0mm, 0mm) angle=-12.62911deg plane=XY)
  RotorAir_1 [vacuum] = polyline(z=0mm, xy in mm: (85.5, 0) (86.5, 0) (86.479415, 1.8869876) (86.417671, 3.773077) (85.5, 0), closed, covered, AngularArc from point 1 over 3 centre=(0mm, 0mm, 0mm) angle=2.5deg plane=XY)
  Rotor_Pocket [vacuum] = polyline(z=0mm, xy in mm: (55.026141, 43.541145) (61.678073, 46.296466) (60.772198, 48.483442) (65.53085, 55.538434) (64.856648, 56.324286) (64.173022, 57.101954) (55.026141, 43.541145), closed, covered, AngularArc from point 3 over 3 centre=(0mm, 0mm, 0mm) angle=1.3812816deg plane=XY)
  Rotor_Pocket_1 [vacuum] = polyline(z=0mm, xy in mm: (68.05317, 52.417326) (67.572091, 53.036049) (67.085387, 53.650358) (62.6581, 47.327537) (63.338715, 45.684386) (68.05317, 52.417326), closed, covered, AngularArc from point 0 over 3 centre=(0mm, 0mm, 0mm) angle=1.0455281deg plane=XY)
  Rotor_Pocket_2 [vacuum] = polyline(z=0mm, xy in mm: (65.188718, 43.831209) (69.645759, 50.196522) (69.27328, 50.709321) (68.897025, 51.219356) (64.644226, 45.145729) (65.188718, 43.831209), closed, covered, AngularArc from point 1 over 3 centre=(0mm, 0mm, 0mm) angle=0.84599149deg plane=XY)
  Rotor_Pocket_3 [vacuum] = polyline(z=0mm, xy in mm: (71.908443, 46.806152) (71.488162, 47.445576) (71.062196, 48.081226) (66.812269, 43.831299) (70.692563, 45.438569) (70.64813, 45.54584) (71.908443, 46.806152), closed, covered, AngularArc from point 0 over 3 centre=(0mm, 0mm, 0mm) angle=1.0219498deg plane=XY)
  Rotor_Pocket_4 [vacuum] = polyline(z=0mm, xy in mm: (62.508183, 44.292404) (62.060757, 45.372586) (55.408824, 42.617265) (69.314913, 9.044998) (75.966845, 11.800319) (75.519419, 12.8805) (69.052263, 10.201716) (56.041026, 41.61362) (62.508183, 44.292404), closed, covered)
  coordinate_system CS_L1_1Magnet2N1_1_1 = origin=(62.527414mm, 35.100036mm, 0mm) x=(1.2102822mm, 0.5013153mm, 0mm) y=(-0.5013153mm, 1.2102822mm, 0mm)
  L1_1Magnet2N1_1_1 [N42UH, oriented by CS_L1_1Magnet2N1_1_1] = polyline(z=0mm, xy in mm: (62.508183, 44.292404) (56.041026, 41.61362) (62.546644, 25.907668) (69.013801, 28.586452) (62.508183, 44.292404), closed, covered)
  coordinate_system CS_L1_1Magnet3N1_1_1 = origin=(69.033032mm, 19.394084mm, 0mm) x=(1.2102822mm, 0.5013153mm, 0mm) y=(-0.5013153mm, 1.2102822mm, 0mm)
  L1_1Magnet3N1_1_1 [N42UH, oriented by CS_L1_1Magnet3N1_1_1] = polyline(z=0mm, xy in mm: (75.519419, 12.8805) (69.013801, 28.586452) (62.546644, 25.907668) (69.052263, 10.201716) (75.519419, 12.8805), closed, covered)
  Rotor_Pocket_5 [vacuum] = polyline(z=0mm, xy in mm: (71.429953, 43.658354) (70.960442, 44.791854) (67.080148, 43.184583) (77.968939, 16.896716) (81.849233, 18.503986) (81.379722, 19.637486) (77.684204, 18.106752) (67.734435, 42.12762) (71.429953, 43.658354), closed, covered)
  coordinate_system CS_L4_1Magnet2N1_1_1 = origin=(72.069636mm, 36.88777mm, 0mm) x=(1.2102822mm, 0.5013153mm, 0mm) y=(-0.5013153mm, 1.2102822mm, 0mm)
  L4_1Magnet2N1_1_1 [N42UH, oriented by CS_L4_1Magnet2N1_1_1] = polyline(z=0mm, xy in mm: (71.429953, 43.658354) (67.734435, 42.12762) (72.709319, 30.117186) (76.404837, 31.64792) (71.429953, 43.658354), closed, covered)
  coordinate_system CS_L4_1Magnet3N1_1_1 = origin=(77.044521mm, 24.877336mm, 0mm) x=(1.2102822mm, 0.5013153mm, 0mm) y=(-0.5013153mm, 1.2102822mm, 0mm)
  L4_1Magnet3N1_1_1 [N42UH, oriented by CS_L4_1Magnet3N1_1_1] = polyline(z=0mm, xy in mm: (81.379722, 19.637486) (76.404837, 31.64792) (72.709319, 30.117186) (77.684204, 18.106752) (81.379722, 19.637486), closed, covered)
  Rotor_Pocket_6 [vacuum] = polyline(z=0mm, xy in mm: (82.161544, 17.75) (82.117111, 17.85727) (78.236817, 16.25) (84.247122, 16.25) (84.098853, 17.000676) (83.943895, 17.75) (82.161544, 17.75), closed, covered, AngularArc from point 3 over 3 centre=(0mm, 0mm, 0mm) angle=1.0219498deg plane=XY)
  Rotor_Pocket_7 [vacuum] = polyline(z=0mm, xy in mm: (84.935108, 12.5) (84.84051, 13.126701) (84.741289, 13.752687) (77.08873, 15.10204) (77.633222, 13.787519) (84.935108, 12.5), closed, covered, AngularArc from point 0 over 3 centre=(0mm, 0mm, 0mm) angle=0.84599149deg plane=XY)
  Stator [M250-35A_20C] = polyline(z=0mm, xy in mm: (87.24155, 6.7202587) (88.239409, 6.7856621) (89.295326, 8.2257514) (110.91288, 11.071756) (111.66805, 10.861216) (112.03931, 10.170717) (112.25913, 7.357852) (112.40834, 4.5403587) (112.13039, 3.8073091) (111.40916, 3.5) (89.605069, 3.5) (88.370216, 4.7899443) (87.372357, 4.7245411) (87.468083, 2.3631326) (87.5, -3.7481129e-13) (125, 0) (115.48494, 47.835429) (88.388348, 88.388348) (61.871843, 61.871843) (63.520262, 60.178288) (65.122341, 58.440831) (65.874181, 59.100177) (65.835225, 60.885478) (81.253043, 76.303296) (81.980334, 76.595985) (82.695219, 76.274182) (84.581978, 74.176404) (86.415537, 72.031971) (86.641277, 71.281198) (86.256161, 70.598334) (68.957815, 57.324846) (67.192872, 57.596497) (66.441033, 56.937151) (69.418417, 53.266625) (72.19327, 49.44069) (73.024739, 49.99626) (73.219145, 51.771373) (90.517491, 65.04486) (91.276763, 65.240115) (91.943528, 64.827754) (93.540331, 62.501651) (95.078299, 60.136237) (95.204112, 59.362422) (94.733159, 58.735667) (75.850266, 47.833623) (74.13588, 48.333321) (73.30441, 47.777751) (75.777223, 43.75) (78.028951, 39.594605) (78.925824, 40.036894) (79.350266, 41.771445) (98.233159, 52.673489) (99.011421, 52.767969) (99.618658, 52.272105) (100.89818, 49.757478) (102.11425, 47.211555) (102.13798, 46.427938) (101.58925, 45.868017) (81.444897, 37.523954) (79.810401, 38.243149) (78.913528, 37.80086) (80.839459, 33.4848) (82.529536, 29.071046) (83.476466, 29.392486) (84.123681, 31.056797) (104.26803, 39.40086) (105.05197, 39.392948) (105.58929, 38.822065) (106.52964, 36.16194) (107.40299, 33.47907) (107.32424, 32.699059) (106.70711, 32.215552) (85.645983, 26.572239) (84.119345, 27.498626) (83.172415, 27.177186) (84.51851, 22.646666) (85.618017, 18.050073) (86.598802, 18.245164) (87.457717, 19.810758) (108.51885, 25.454071) (109.29504, 25.343902) (109.75325, 24.70777) (110.33834, 21.947661) (110.85404, 19.173748) (110.67415, 18.41069) (109.99919, 18.01187) (88.381643, 15.165865) (86.988983, 16.283593) (86.008198, 16.088503) (86.751425, 11.421042) (87.24155, 6.7202587), closed, covered, AngularArc from point 3 over 3 centre=(111.0434mm, 10.080311mm, 0mm) angle=-92.313014deg plane=XY, AngularArc from point 5 over 3 centre=(0mm, 0mm, 0mm) angle=-2.8739721deg plane=XY, AngularArc from point 7 over 3 centre=(111.40916mm, 4.5mm, 0mm) angle=-92.313014deg plane=XY, AngularArc from point 12 over 3 centre=(0mm, 0mm, 0mm) angle=-3.0951768deg plane=XY, AngularArc from point 15 over 3 centre=(0mm, 0mm, 0mm) angle=45deg plane=XY, AngularArc from point 18 over 3 centre=(0mm, 0mm, 0mm) angle=-3.095177deg plane=XY, AngularArc from point 23 over 3 centre=(81.96015mm, 75.596189mm, 0mm) angle=-92.313014deg plane=XY, AngularArc from point 25 over 3 centre=(0mm, 0mm, 0mm) angle=-2.873972deg plane=XY, AngularArc from point 27 over 3 centre=(85.647399mm, 71.391687mm, 0mm) angle=-92.313014deg plane=XY, AngularArc from point 32 over 3 centre=(0mm, 0mm, 0mm) angle=-6.190354deg plane=XY, AngularArc from point 37 over 3 centre=(91.126252mm, 64.251507mm, 0mm) angle=-92.313014deg plane=XY, AngularArc from point 39 over 3 centre=(0mm, 0mm, 0mm) angle=-2.873972deg plane=XY, AngularArc from point 41 over 3 centre=(94.233159mm, 59.601692mm, 0mm) angle=-92.313014deg plane=XY, AngularArc from point 46 over 3 centre=(0mm, 0mm, 0mm) angle=-6.190354deg plane=XY, AngularArc from point 51 over 3 centre=(98.733159mm, 51.807464mm, 0mm) angle=-92.313014deg plane=XY, AngularArc from point 53 over 3 centre=(0mm, 0mm, 0mm) angle=-2.873972deg plane=XY, AngularArc from point 55 over 3 centre=(101.20656mm, 46.791896mm, 0mm) angle=-92.313014deg plane=XY, AngularArc from point 60 over 3 centre=(0mm, 0mm, 0mm) angle=-6.190354deg plane=XY, AngularArc from point 65 over 3 centre=(104.65071mm, 38.47698mm, 0mm) angle=-92.313014deg plane=XY, AngularArc from point 67 over 3 centre=(0mm, 0mm, 0mm) angle=-2.873972deg plane=XY, AngularArc from point 69 over 3 centre=(106.4483mm, 33.181478mm, 0mm) angle=-92.313014deg plane=XY, AngularArc from point 74 over 3 centre=(0mm, 0mm, 0mm) angle=-6.190354deg plane=XY, AngularArc from point 79 over 3 centre=(108.77767mm, 24.488145mm, 0mm) angle=-92.313014deg plane=XY, AngularArc from point 81 over 3 centre=(0mm, 0mm, 0mm) angle=-2.873972deg plane=XY, AngularArc from point 83 over 3 centre=(109.86867mm, 19.003315mm, 0mm) angle=-92.313014deg plane=XY, AngularArc from point 88 over 3 centre=(0mm, 0mm, 0mm) angle=-6.1903538deg plane=XY)
  Rotor_Pocket_8 [vacuum] = polyline(z=0mm, xy in mm: (85.373064, 9.5) (85.282834, 10.278534) (85.185505, 11.056212) (77.090974, 12.483496) (77.771589, 10.840345) (85.373064, 9.5), closed, covered, AngularArc from point 0 over 3 centre=(0mm, 0mm, 0mm) angle=1.0455281deg plane=XY)
  Rotor_Pocket_9 [vacuum] = polyline(z=0mm, xy in mm: (85.754358, 5) (85.68786, 6.033291) (85.608912, 7.0657053) (77.255404, 8.6894628) (76.349529, 10.876439) (69.697596, 8.1211184) (85.754358, 5), closed, covered, AngularArc from point 0 over 3 centre=(0mm, 0mm, 0mm) angle=1.3812816deg plane=XY)
  Rotating_Band_mid [vacuum] = user_primitive(RMxprt/Band.dll, DiaGap=DiaGap - (2 * (Airgap - Banding_Thickness)) + (4 * (((airgap - Banding_Thickness - Sleeve_Thickness) / 4) * 1)), DiaYoke=Shaft_Hole_Diameter, Length=0mm, SegAngle=0deg, Fractions=SymmetryFactor, HalfAxial=HalfAxial, InfoCore=0)
  Rotating_Band_in [vacuum] = user_primitive(RMxprt/Band.dll, DiaGap=DiaGap - (2 * (Airgap - Banding_Thickness)) + (4 * (((airgap - Banding_Thickness - Sleeve_Thickness) / 4) * 0.5)), DiaYoke=Shaft_Hole_Diameter, Length=0mm, SegAngle=0deg, Fractions=SymmetryFactor, HalfAxial=HalfAxial, InfoCore=0)
  Rotating_Band_out [vacuum] = user_primitive(RMxprt/Band.dll, DiaGap=DiaGap - (2 * (Airgap - Banding_Thickness)) + (4 * (((airgap - Banding_Thickness - Sleeve_Thickness) / 4) * 1.5)), DiaYoke=Shaft_Hole_Diameter, Length=0mm, SegAngle=0deg, Fractions=SymmetryFactor, HalfAxial=HalfAxial, InfoCore=0)
  Ph1_P2_C1_1 = user_primitive(RMxprt/LapCoil.dll, DiaGap=175mm, DiaYoke=DiaStatorYoke, Length=Stator_Lam_Length, Skew=StatorSkewAngle, Slots=SlotNumber_Stator, SlotType=SlotType_Stator, Hs0=Hs0_Stator, Hs1=Hs1_Stator, Hs2=21.757403mm, Bs0=Bs0_Stator, Bs1=4.7358913mm, Bs2=7.5880024mm, Rs=Rs_Stator, FilletType=1, Layers=Layers, CoilPitch=5, EndExt=WdgExt_F, SpanExt=SpanExt, BendAngle=0deg, SegAngle=15deg, LenRegion=Model_Length, InfoCoil=1)
  Ph1_P2_C1_1.rotate(axis=Z, angle=0deg)
  Ph2_P2_C1_1 [Copper (Annealed)_40C] = user_primitive(RMxprt/LapCoil.dll, DiaGap=175mm, DiaYoke=DiaStatorYoke, Length=Stator_Lam_Length, Skew=StatorSkewAngle, Slots=SlotNumber_Stator, SlotType=SlotType_Stator, Hs0=Hs0_Stator, Hs1=Hs1_Stator, Hs2=21.757403mm, Bs0=Bs0_Stator, Bs1=4.7358913mm, Bs2=7.5880024mm, Rs=Rs_Stator, FilletType=1, Layers=Layers, CoilPitch=5, EndExt=WdgExt_F, SpanExt=SpanExt, BendAngle=0deg, SegAngle=15deg, LenRegion=Model_Length, InfoCoil=1)
  Ph2_P2_C1_1.rotate(axis=Z, angle=15deg)
  Ph2_P2_C2_1 = user_primitive(RMxprt/LapCoil.dll, DiaGap=175mm, DiaYoke=DiaStatorYoke, Length=Stator_Lam_Length, Skew=StatorSkewAngle, Slots=SlotNumber_Stator, SlotType=SlotType_Stator, Hs0=Hs0_Stator, Hs1=Hs1_Stator, Hs2=21.757403mm, Bs0=Bs0_Stator, Bs1=4.7358913mm, Bs2=7.5880024mm, Rs=Rs_Stator, FilletType=1, Layers=Layers, CoilPitch=5, EndExt=WdgExt_F, SpanExt=SpanExt, BendAngle=0deg, SegAngle=15deg, LenRegion=Model_Length, InfoCoil=1)
  Ph2_P2_C2_1.rotate(axis=Z, angle=330deg)
  Ph3_P1_C1_1 [Copper (Annealed)_40C] = user_primitive(RMxprt/LapCoil.dll, DiaGap=175mm, DiaYoke=DiaStatorYoke, Length=Stator_Lam_Length, Skew=StatorSkewAngle, Slots=SlotNumber_Stator, SlotType=SlotType_Stator, Hs0=Hs0_Stator, Hs1=Hs1_Stator, Hs2=21.757403mm, Bs0=Bs0_Stator, Bs1=4.7358913mm, Bs2=7.5880024mm, Rs=Rs_Stator, FilletType=1, Layers=Layers, CoilPitch=5, EndExt=WdgExt_F, SpanExt=SpanExt, BendAngle=0deg, SegAngle=15deg, LenRegion=Model_Length, InfoCoil=1)
  Ph3_P1_C1_1.rotate(axis=Z, angle=30deg)
  Ph3_P1_C2_1 = user_primitive(RMxprt/LapCoil.dll, DiaGap=175mm, DiaYoke=DiaStatorYoke, Length=Stator_Lam_Length, Skew=StatorSkewAngle, Slots=SlotNumber_Stator, SlotType=SlotType_Stator, Hs0=Hs0_Stator, Hs1=Hs1_Stator, Hs2=21.757403mm, Bs0=Bs0_Stator, Bs1=4.7358913mm, Bs2=7.5880024mm, Rs=Rs_Stator, FilletType=1, Layers=Layers, CoilPitch=5, EndExt=WdgExt_F, SpanExt=SpanExt, BendAngle=0deg, SegAngle=15deg, LenRegion=Model_Length, InfoCoil=1)
  Ph3_P1_C2_1.rotate(axis=Z, angle=345deg)
  Ph1_P2_C1_2 [Copper (Annealed)_40C] = Ph1_P2_C1_1.separate_bodies()
  Ph1_P2_C1_1.delete()
  Ph2_P2_C1_1.separate_bodies()
  Ph2_P2_C2_2 [Copper (Annealed)_40C] = Ph2_P2_C2_1.separate_bodies()
  Ph2_P2_C2_1.delete()
  Ph3_P1_C1_1.separate_bodies()
  Ph3_P1_C2_2 [Copper (Annealed)_40C] = Ph3_P1_C2_1.separate_bodies()
  Ph3_P1_C2_1.delete()
  Band_Tool = user_primitive(RMxprt/Band.dll, DiaGap=1mm, DiaYoke=DiaOuter, Length=0mm, SegAngle=SegAngle, Fractions=SymmetryFactor, HalfAxial=HalfAxial, InfoCore=1)
  Whole_Region [vacuum] = user_primitive(RMxprt/Band.dll, DiaGap=DiaGap+Airgap, DiaYoke=DiaOuter, Length=0mm, SegAngle=SegAngle, Fractions=SymmetryFactor, HalfAxial=HalfAxial, InfoCore=100)
  Band_Tool_1 = Band_Tool.copy()
  Rotor_1.subtract(Band_Tool_1)
  Band_Tool_2 = Band_Tool.copy()
  RotorAir.subtract(Band_Tool_2)
  Band_Tool_3 = Band_Tool.copy()
  RotorDuctFluidRegion.subtract(Band_Tool_3)
  Band_Tool_4 = Band_Tool.copy()
  Shaft.subtract(Band_Tool_4)
  Band_Tool_5 = Band_Tool.copy()
  RotorDuctFluidRegion_1.subtract(Band_Tool_5)
  Band_Tool_6 = Band_Tool.copy()
  RotorAir_1.subtract(Band_Tool_6)
  Band_Tool_7 = Band_Tool.copy()
  Rotor_Pocket.subtract(Band_Tool_7)
  Band_Tool_8 = Band_Tool.copy()
  Rotor_Pocket_1.subtract(Band_Tool_8)
  Band_Tool_9 = Band_Tool.copy()
  Rotor_Pocket_2.subtract(Band_Tool_9)
  Band_Tool_10 = Band_Tool.copy()
  Rotor_Pocket_3.subtract(Band_Tool_10)
  Band_Tool_11 = Band_Tool.copy()
  Rotor_Pocket_4.subtract(Band_Tool_11)
  Band_Tool_12 = Band_Tool.copy()
  L1_1Magnet2N1_1_1.subtract(Band_Tool_12)
  Band_Tool_13 = Band_Tool.copy()
  L1_1Magnet3N1_1_1.subtract(Band_Tool_13)
  Band_Tool_14 = Band_Tool.copy()
  Rotor_Pocket_5.subtract(Band_Tool_14)
  Band_Tool_15 = Band_Tool.copy()
  L4_1Magnet2N1_1_1.subtract(Band_Tool_15)
  Band_Tool_16 = Band_Tool.copy()
  L4_1Magnet3N1_1_1.subtract(Band_Tool_16)
  Band_Tool_17 = Band_Tool.copy()
  Rotor_Pocket_6.subtract(Band_Tool_17)
  Band_Tool_18 = Band_Tool.copy()
  Rotor_Pocket_7.subtract(Band_Tool_18)
  Band_Tool_19 = Band_Tool.copy()
  Stator.subtract(Band_Tool_19)
  Band_Tool_20 = Band_Tool.copy()
  Rotor_Pocket_8.subtract(Band_Tool_20)
  Band_Tool_21 = Band_Tool.copy()
  Rotor_Pocket_9.subtract(Band_Tool_21)
  Band_Tool_22 = Band_Tool.copy()
  Rotating_Band_mid.subtract(Band_Tool_22)
  Band_Tool_23 = Band_Tool.copy()
  Rotating_Band_in.subtract(Band_Tool_23)
  Band_Tool_24 = Band_Tool.copy()
  Rotating_Band_out.subtract(Band_Tool_24)
  Band_Tool_26 = Band_Tool.copy()
  Ph2_P2_C1_1.subtract(Band_Tool_26)
  Band_Tool_28 = Band_Tool.copy()
  Ph3_P1_C1_1.subtract(Band_Tool_28)
  Band_Tool_30 = Band_Tool.copy()
  Ph1_P2_C1_2.subtract(Band_Tool_30)
  Band_Tool_32 = Band_Tool.copy()
  Ph2_P2_C2_2.subtract(Band_Tool_32)
  Band_Tool_34 = Band_Tool.copy()
  Ph3_P1_C2_2.subtract(Band_Tool_34)
  Whole_Region.subtract(Band_Tool)
  Boundary_Independent [vacuum] = user_primitive(RMxprt/Band.dll, DiaGap=DiaGap+Airgap, DiaYoke=DiaOuter, Length=0mm, SegAngle=SegAngle, Fractions=SymmetryFactor, HalfAxial=HalfAxial, InfoCore=2)
  Boundary_Dependent [vacuum] = user_primitive(RMxprt/Band.dll, DiaGap=DiaGap+Airgap, DiaYoke=DiaOuter, Length=0mm, SegAngle=SegAngle, Fractions=SymmetryFactor, HalfAxial=HalfAxial, InfoCore=3)
  Slot_1_CondTurn_1_Conductor_75_L [copper] = circle(normal=Z, centre=(88.426504mm, 18.082405mm, 0mm), radius=0.45405mm, segments=8)
  Slot_1_CondTurn_1_Conductor_38_R [copper] = circle(normal=Z, centre=(89.319482mm, 16.215653mm, 0mm), radius=0.45405mm, segments=8)
  Slot_1_CondTurn_1_Conductor_37_L [copper] = circle(normal=Z, centre=(88.725903mm, 19.199776mm, 0mm), radius=0.45405mm, segments=8)
  Slot_1_CondTurn_1_Conductor_74_R [copper] = circle(normal=Z, centre=(89.762166mm, 17.284386mm, 0mm), radius=0.45405mm, segments=8)
  Slot_1_CondTurn_1_Conductor_73_L [copper] = circle(normal=Z, centre=(89.543876mm, 18.381803mm, 0mm), radius=0.45405mm, segments=8)
  Slot_1_CondTurn_1_Conductor_36_R [copper] = circle(normal=Z, centre=(90.466373mm, 16.366644mm, 0mm), radius=0.45405mm, segments=8)
  Slot_1_CondTurn_1_Conductor_35_L [copper] = circle(normal=Z, centre=(89.843274mm, 19.499175mm, 0mm), radius=0.45405mm, segments=8)
  Slot_1_CondTurn_1_Conductor_72_R [copper] = circle(normal=Z, centre=(90.909057mm, 17.435377mm, 0mm), radius=0.45405mm, segments=8)
  Slot_1_CondTurn_1_Conductor_71_L [copper] = circle(normal=Z, centre=(90.661247mm, 18.681202mm, 0mm), radius=0.45405mm, segments=8)
  Slot_1_CondTurn_1_Conductor_33_L [copper] = circle(normal=Z, centre=(90.960646mm, 19.798574mm, 0mm), radius=0.45405mm, segments=8)
  Slot_1_CondTurn_1_Conductor_34_R [copper] = circle(normal=Z, centre=(91.613265mm, 16.517635mm, 0mm), radius=0.45405mm, segments=8)
  Slot_1_CondTurn_1_Conductor_70_R [copper] = circle(normal=Z, centre=(92.055949mm, 17.586368mm, 0mm), radius=0.45405mm, segments=8)
  Slot_1_CondTurn_1_Conductor_69_L [copper] = circle(normal=Z, centre=(91.778618mm, 18.980601mm, 0mm), radius=0.45405mm, segments=8)
  Slot_1_CondTurn_1_Conductor_31_L [copper] = circle(normal=Z, centre=(92.078017mm, 20.097972mm, 0mm), radius=0.45405mm, segments=8)
  Slot_1_CondTurn_1_Conductor_32_R [copper] = circle(normal=Z, centre=(92.760156mm, 16.668626mm, 0mm), radius=0.45405mm, segments=8)
  Slot_1_CondTurn_2_Conductor_67_L [copper] = circle(normal=Z, centre=(92.89599mm, 19.28mm, 0mm), radius=0.45405mm, segments=8)
  Slot_1_CondTurn_2_Conductor_68_R [copper] = circle(normal=Z, centre=(93.20284mm, 17.737359mm, 0mm), radius=0.45405mm, segments=8)
  Slot_1_CondTurn_2_Conductor_29_L [copper] = circle(normal=Z, centre=(93.195388mm, 20.397371mm, 0mm), radius=0.45405mm, segments=8)
  Slot_1_CondTurn_2_Conductor_30_R [copper] = circle(normal=Z, centre=(93.907048mm, 16.819618mm, 0mm), radius=0.45405mm, segments=8)
  Slot_1_CondTurn_2_Conductor_66_R [copper] = circle(normal=Z, centre=(94.349731mm, 17.88835mm, 0mm), radius=0.45405mm, segments=8)
  Slot_1_CondTurn_2_Conductor_65_L [copper] = circle(normal=Z, centre=(94.013361mm, 19.579398mm, 0mm), radius=0.45405mm, segments=8)
  Slot_1_CondTurn_2_Conductor_27_L [copper] = circle(normal=Z, centre=(94.31276mm, 20.69677mm, 0mm), radius=0.45405mm, segments=8)
  Slot_1_CondTurn_2_Conductor_28_R [copper] = circle(normal=Z, centre=(95.053939mm, 16.970609mm, 0mm), radius=0.45405mm, segments=8)
  Slot_1_CondTurn_2_Conductor_63_L [copper] = circle(normal=Z, centre=(95.130732mm, 19.878797mm, 0mm), radius=0.45405mm, segments=8)
  Slot_1_CondTurn_2_Conductor_64_R [copper] = circle(normal=Z, centre=(95.496623mm, 18.039341mm, 0mm), radius=0.45405mm, segments=8)
  Slot_1_CondTurn_2_Conductor_25_L [copper] = circle(normal=Z, centre=(95.430131mm, 20.996169mm, 0mm), radius=0.45405mm, segments=8)
  Slot_1_CondTurn_2_Conductor_26_R [copper] = circle(normal=Z, centre=(96.200831mm, 17.1216mm, 0mm), radius=0.45405mm, segments=8)
  Slot_1_CondTurn_2_Conductor_61_L [copper] = circle(normal=Z, centre=(96.248104mm, 20.178196mm, 0mm), radius=0.45405mm, segments=8)
  Slot_1_CondTurn_2_Conductor_62_R [copper] = circle(normal=Z, centre=(96.643514mm, 18.190333mm, 0mm), radius=0.45405mm, segments=8)
  Slot_1_CondTurn_2_Conductor_23_L [copper] = circle(normal=Z, centre=(96.547503mm, 21.295567mm, 0mm), radius=0.45405mm, segments=8)
  Slot_1_CondTurn_3_Conductor_24_R [copper] = circle(normal=Z, centre=(97.347722mm, 17.272591mm, 0mm), radius=0.45405mm, segments=8)
  Slot_1_CondTurn_3_Conductor_60_R [copper] = circle(normal=Z, centre=(97.790406mm, 18.341324mm, 0mm), radius=0.45405mm, segments=8)
  Slot_1_CondTurn_3_Conductor_59_L [copper] = circle(normal=Z, centre=(97.365475mm, 20.477595mm, 0mm), radius=0.45405mm, segments=8)
  Slot_1_CondTurn_3_Conductor_21_L [copper] = circle(normal=Z, centre=(97.664874mm, 21.594966mm, 0mm), radius=0.45405mm, segments=8)
  Slot_1_CondTurn_3_Conductor_22_R [copper] = circle(normal=Z, centre=(98.494614mm, 17.423582mm, 0mm), radius=0.45405mm, segments=8)
  Slot_1_CondTurn_3_Conductor_57_L [copper] = circle(normal=Z, centre=(98.482847mm, 20.776993mm, 0mm), radius=0.45405mm, segments=8)
  Slot_1_CondTurn_3_Conductor_58_R [copper] = circle(normal=Z, centre=(98.937297mm, 18.492315mm, 0mm), radius=0.45405mm, segments=8)
  Slot_1_CondTurn_3_Conductor_20_R [copper] = circle(normal=Z, centre=(99.641505mm, 17.574573mm, 0mm), radius=0.45405mm, segments=8)
  Slot_1_CondTurn_4_Conductor_19_L [copper] = circle(normal=Z, centre=(98.782245mm, 21.894365mm, 0mm), radius=0.45405mm, segments=8)
  Slot_1_CondTurn_3_Conductor_90_L [copper] = circle(normal=Z, centre=(99.300819mm, 19.959021mm, 0mm), radius=0.45405mm, segments=8)
  Slot_1_CondTurn_3_Conductor_56_R [copper] = circle(normal=Z, centre=(100.08419mm, 18.643306mm, 0mm), radius=0.45405mm, segments=8)
  Slot_1_CondTurn_3_Conductor_55_L [copper] = circle(normal=Z, centre=(99.600218mm, 21.076392mm, 0mm), radius=0.45405mm, segments=8)
  Slot_1_CondTurn_3_Conductor_18_R [copper] = circle(normal=Z, centre=(100.7884mm, 17.725564mm, 0mm), radius=0.45405mm, segments=8)
  Slot_1_CondTurn_4_Conductor_17_L [copper] = circle(normal=Z, centre=(99.899617mm, 22.193764mm, 0mm), radius=0.45405mm, segments=8)
  Slot_1_CondTurn_3_Conductor_89_L [copper] = circle(normal=Z, centre=(100.41819mm, 20.25842mm, 0mm), radius=0.45405mm, segments=8)
  Slot_1_CondTurn_3_Conductor_54_R [copper] = circle(normal=Z, centre=(101.23108mm, 18.794297mm, 0mm), radius=0.45405mm, segments=8)
  Slot_1_CondTurn_4_Conductor_53_L [copper] = circle(normal=Z, centre=(100.71759mm, 21.375791mm, 0mm), radius=0.45405mm, segments=8)
  Slot_1_CondTurn_4_Conductor_15_L [copper] = circle(normal=Z, centre=(101.01699mm, 22.493162mm, 0mm), radius=0.45405mm, segments=8)
  Slot_1_CondTurn_3_Conductor_16_R [copper] = circle(normal=Z, centre=(101.93529mm, 17.876555mm, 0mm), radius=0.45405mm, segments=8)
  Slot_1_CondTurn_4_Conductor_88_L [copper] = circle(normal=Z, centre=(101.53556mm, 20.557818mm, 0mm), radius=0.45405mm, segments=8)
  Slot_1_CondTurn_4_Conductor_52_R [copper] = circle(normal=Z, centre=(102.37797mm, 18.945288mm, 0mm), radius=0.45405mm, segments=8)
  Slot_1_CondTurn_4_Conductor_51_L [copper] = circle(normal=Z, centre=(101.83496mm, 21.67519mm, 0mm), radius=0.45405mm, segments=8)
  Slot_1_CondTurn_4_Conductor_13_L [copper] = circle(normal=Z, centre=(102.13436mm, 22.792561mm, 0mm), radius=0.45405mm, segments=8)
  Slot_1_CondTurn_4_Conductor_14_R [copper] = circle(normal=Z, centre=(103.08218mm, 18.027547mm, 0mm), radius=0.45405mm, segments=8)
  Slot_1_CondTurn_4_Conductor_87_L [copper] = circle(normal=Z, centre=(102.65293mm, 20.857217mm, 0mm), radius=0.45405mm, segments=8)
  Slot_1_CondTurn_4_Conductor_50_R [copper] = circle(normal=Z, centre=(103.52486mm, 19.096279mm, 0mm), radius=0.45405mm, segments=8)
  Slot_1_CondTurn_4_Conductor_49_L [copper] = circle(normal=Z, centre=(102.95233mm, 21.974588mm, 0mm), radius=0.45405mm, segments=8)
  Slot_1_CondTurn_4_Conductor_11_L [copper] = circle(normal=Z, centre=(103.25173mm, 23.09196mm, 0mm), radius=0.45405mm, segments=8)
  Slot_1_CondTurn_5_Conductor_12_R [copper] = circle(normal=Z, centre=(104.22907mm, 18.178538mm, 0mm), radius=0.45405mm, segments=8)
  Slot_1_CondTurn_4_Conductor_86_L [copper] = circle(normal=Z, centre=(103.7703mm, 21.156616mm, 0mm), radius=0.45405mm, segments=8)
  Slot_1_CondTurn_5_Conductor_48_R [copper] = circle(normal=Z, centre=(104.67175mm, 19.24727mm, 0mm), radius=0.45405mm, segments=8)
  Slot_1_CondTurn_4_Conductor_47_L [copper] = circle(normal=Z, centre=(104.0697mm, 22.273987mm, 0mm), radius=0.45405mm, segments=8)
  Slot_1_CondTurn_6_Conductor_9_L [copper] = circle(normal=Z, centre=(104.3691mm, 23.391359mm, 0mm), radius=0.45405mm, segments=8)
  Slot_1_CondTurn_5_Conductor_10_R [copper] = circle(normal=Z, centre=(105.37596mm, 18.329529mm, 0mm), radius=0.45405mm, segments=8)
  Slot_1_CondTurn_5_Conductor_85_R [copper] = circle(normal=Z, centre=(105.11444mm, 20.316003mm, 0mm), radius=0.45405mm, segments=8)
  Slot_1_CondTurn_5_Conductor_84_L [copper] = circle(normal=Z, centre=(104.88768mm, 21.456015mm, 0mm), radius=0.45405mm, segments=8)
  Slot_1_CondTurn_5_Conductor_45_L [copper] = circle(normal=Z, centre=(105.18707mm, 22.573386mm, 0mm), radius=0.45405mm, segments=8)
  Slot_1_CondTurn_5_Conductor_46_R [copper] = circle(normal=Z, centre=(105.81865mm, 19.398262mm, 0mm), radius=0.45405mm, segments=8)
  Slot_1_CondTurn_5_Conductor_8_R [copper] = circle(normal=Z, centre=(106.52285mm, 18.48052mm, 0mm), radius=0.45405mm, segments=8)
  Slot_1_CondTurn_6_Conductor_7_L [copper] = circle(normal=Z, centre=(105.48647mm, 23.690757mm, 0mm), radius=0.45405mm, segments=8)
  Slot_1_CondTurn_5_Conductor_83_R [copper] = circle(normal=Z, centre=(106.26133mm, 20.466994mm, 0mm), radius=0.45405mm, segments=8)
  Slot_1_CondTurn_5_Conductor_82_L [copper] = circle(normal=Z, centre=(106.00505mm, 21.755413mm, 0mm), radius=0.45405mm, segments=8)
  Slot_1_CondTurn_6_Conductor_43_L [copper] = circle(normal=Z, centre=(106.30445mm, 22.872785mm, 0mm), radius=0.45405mm, segments=8)
  Slot_1_CondTurn_5_Conductor_44_R [copper] = circle(normal=Z, centre=(106.96554mm, 19.549253mm, 0mm), radius=0.45405mm, segments=8)
  Slot_1_CondTurn_5_Conductor_6_R [copper] = circle(normal=Z, centre=(107.66975mm, 18.631511mm, 0mm), radius=0.45405mm, segments=8)
  Slot_1_CondTurn_6_Conductor_5_L [copper] = circle(normal=Z, centre=(106.60384mm, 23.990156mm, 0mm), radius=0.45405mm, segments=8)
  Slot_1_CondTurn_6_Conductor_80_L [copper] = circle(normal=Z, centre=(107.12242mm, 22.054812mm, 0mm), radius=0.45405mm, segments=8)
  Slot_1_CondTurn_5_Conductor_81_R [copper] = circle(normal=Z, centre=(107.40822mm, 20.617985mm, 0mm), radius=0.45405mm, segments=8)
  Slot_1_CondTurn_6_Conductor_41_L [copper] = circle(normal=Z, centre=(107.42182mm, 23.172183mm, 0mm), radius=0.45405mm, segments=8)
  Slot_1_CondTurn_5_Conductor_42_R [copper] = circle(normal=Z, centre=(108.11243mm, 19.700244mm, 0mm), radius=0.45405mm, segments=8)
  Slot_1_CondTurn_6_Conductor_3_L [copper] = circle(normal=Z, centre=(107.72122mm, 24.289555mm, 0mm), radius=0.45405mm, segments=8)
  Slot_1_CondTurn_5_Conductor_4_R [copper] = circle(normal=Z, centre=(108.81664mm, 18.782502mm, 0mm), radius=0.45405mm, segments=8)
  Slot_1_CondTurn_6_Conductor_79_R [copper] = circle(normal=Z, centre=(108.55511mm, 20.768977mm, 0mm), radius=0.45405mm, segments=8)
  Slot_1_CondTurn_6_Conductor_78_L [copper] = circle(normal=Z, centre=(108.23979mm, 22.354211mm, 0mm), radius=0.45405mm, segments=8)
  Slot_1_CondTurn_6_Conductor_39_L [copper] = circle(normal=Z, centre=(108.53919mm, 23.471582mm, 0mm), radius=0.45405mm, segments=8)
  Slot_1_CondTurn_6_Conductor_40_R [copper] = circle(normal=Z, centre=(109.25932mm, 19.851235mm, 0mm), radius=0.45405mm, segments=8)
  Slot_1_CondTurn_6_Conductor_1_L [copper] = circle(normal=Z, centre=(108.83859mm, 24.588954mm, 0mm), radius=0.45405mm, segments=8)
  Slot_1_CondTurn_6_Conductor_2_R [copper] = circle(normal=Z, centre=(109.96353mm, 18.933493mm, 0mm), radius=0.45405mm, segments=8)
  Slot_1_CondTurn_6_Conductor_76_L [copper] = circle(normal=Z, centre=(109.35716mm, 22.65361mm, 0mm), radius=0.45405mm, segments=8)
  Slot_1_CondTurn_6_Conductor_77_R [copper] = circle(normal=Z, centre=(109.702mm, 20.919968mm, 0mm), radius=0.45405mm, segments=8)
  [Slot_1_CondTurn_1_Conductor_75_L, Slot_1_CondTurn_1_Conductor_38_R, Slot_1_CondTurn_1_Conductor_37_L, Slot_1_CondTurn_1_Conductor_74_R, Slot_1_CondTurn_1_Conductor_73_L, Slot_1_CondTurn_1_Conductor_36_R, Slot_1_CondTurn_1_Conductor_35_L, Slot_1_CondTurn_1_Conductor_72_R, Slot_1_CondTurn_1_Conductor_71_L, Slot_1_CondTurn_1_Conductor_33_L, Slot_1_CondTurn_1_Conductor_34_R, Slot_1_CondTurn_1_Conductor_70_R, Slot_1_CondTurn_1_Conductor_69_L, Slot_1_CondTurn_1_Conductor_31_L, Slot_1_CondTurn_1_Conductor_32_R, Slot_1_CondTurn_2_Conductor_67_L, Slot_1_CondTurn_2_Conductor_68_R, Slot_1_CondTurn_2_Conductor_29_L, Slot_1_CondTurn_2_Conductor_30_R, Slot_1_CondTurn_2_Conductor_66_R, Slot_1_CondTurn_2_Conductor_65_L, Slot_1_CondTurn_2_Conductor_27_L, Slot_1_CondTurn_2_Conductor_28_R, Slot_1_CondTurn_2_Conductor_63_L, Slot_1_CondTurn_2_Conductor_64_R, Slot_1_CondTurn_2_Conductor_25_L, Slot_1_CondTurn_2_Conductor_26_R, Slot_1_CondTurn_2_Conductor_61_L, Slot_1_CondTurn_2_Conductor_62_R, Slot_1_CondTurn_2_Conductor_23_L, Slot_1_CondTurn_3_Conductor_24_R, Slot_1_CondTurn_3_Conductor_60_R, Slot_1_CondTurn_3_Conductor_59_L, Slot_1_CondTurn_3_Conductor_21_L, Slot_1_CondTurn_3_Conductor_22_R, Slot_1_CondTurn_3_Conductor_57_L, Slot_1_CondTurn_3_Conductor_58_R, Slot_1_CondTurn_3_Conductor_20_R, Slot_1_CondTurn_4_Conductor_19_L, Slot_1_CondTurn_3_Conductor_90_L, Slot_1_CondTurn_3_Conductor_56_R, Slot_1_CondTurn_3_Conductor_55_L, Slot_1_CondTurn_3_Conductor_18_R, Slot_1_CondTurn_4_Conductor_17_L, Slot_1_CondTurn_3_Conductor_89_L, Slot_1_CondTurn_3_Conductor_54_R, Slot_1_CondTurn_4_Conductor_53_L, Slot_1_CondTurn_4_Conductor_15_L, Slot_1_CondTurn_3_Conductor_16_R, Slot_1_CondTurn_4_Conductor_88_L, Slot_1_CondTurn_4_Conductor_52_R, Slot_1_CondTurn_4_Conductor_51_L, Slot_1_CondTurn_4_Conductor_13_L, Slot_1_CondTurn_4_Conductor_14_R, Slot_1_CondTurn_4_Conductor_87_L, Slot_1_CondTurn_4_Conductor_50_R, Slot_1_CondTurn_4_Conductor_49_L, Slot_1_CondTurn_4_Conductor_11_L, Slot_1_CondTurn_5_Conductor_12_R, Slot_1_CondTurn_4_Conductor_86_L, Slot_1_CondTurn_5_Conductor_48_R, Slot_1_CondTurn_4_Conductor_47_L, Slot_1_CondTurn_6_Conductor_9_L, Slot_1_CondTurn_5_Conductor_10_R, Slot_1_CondTurn_5_Conductor_85_R, Slot_1_CondTurn_5_Conductor_84_L, Slot_1_CondTurn_5_Conductor_45_L, Slot_1_CondTurn_5_Conductor_46_R, Slot_1_CondTurn_5_Conductor_8_R, Slot_1_CondTurn_6_Conductor_7_L, Slot_1_CondTurn_5_Conductor_83_R, Slot_1_CondTurn_5_Conductor_82_L, Slot_1_CondTurn_6_Conductor_43_L, Slot_1_CondTurn_5_Conductor_44_R, Slot_1_CondTurn_5_Conductor_6_R, Slot_1_CondTurn_6_Conductor_5_L, Slot_1_CondTurn_6_Conductor_80_L, Slot_1_CondTurn_5_Conductor_81_R, Slot_1_CondTurn_6_Conductor_41_L, Slot_1_CondTurn_5_Conductor_42_R, Slot_1_CondTurn_6_Conductor_3_L, Slot_1_CondTurn_5_Conductor_4_R, Slot_1_CondTurn_6_Conductor_79_R, Slot_1_CondTurn_6_Conductor_78_L, Slot_1_CondTurn_6_Conductor_39_L, Slot_1_CondTurn_6_Conductor_40_R, Slot_1_CondTurn_6_Conductor_1_L, Slot_1_CondTurn_6_Conductor_2_R, Slot_1_CondTurn_6_Conductor_76_L, Slot_1_CondTurn_6_Conductor_77_R].rotate(axis=Z, angle=-7.5deg)
  [Slot_1_CondTurn_1_Conductor_75_L, Slot_1_CondTurn_1_Conductor_38_R, Slot_1_CondTurn_1_Conductor_37_L, Slot_1_CondTurn_1_Conductor_74_R, Slot_1_CondTurn_1_Conductor_73_L, Slot_1_CondTurn_1_Conductor_36_R, Slot_1_CondTurn_1_Conductor_35_L, Slot_1_CondTurn_1_Conductor_72_R, Slot_1_CondTurn_1_Conductor_71_L, Slot_1_CondTurn_1_Conductor_33_L, Slot_1_CondTurn_1_Conductor_34_R, Slot_1_CondTurn_1_Conductor_70_R, Slot_1_CondTurn_1_Conductor_69_L, Slot_1_CondTurn_1_Conductor_31_L, Slot_1_CondTurn_1_Conductor_32_R, Slot_1_CondTurn_2_Conductor_67_L, Slot_1_CondTurn_2_Conductor_68_R, Slot_1_CondTurn_2_Conductor_29_L, Slot_1_CondTurn_2_Conductor_30_R, Slot_1_CondTurn_2_Conductor_66_R, Slot_1_CondTurn_2_Conductor_65_L, Slot_1_CondTurn_2_Conductor_27_L, Slot_1_CondTurn_2_Conductor_28_R, Slot_1_CondTurn_2_Conductor_63_L, Slot_1_CondTurn_2_Conductor_64_R, Slot_1_CondTurn_2_Conductor_25_L, Slot_1_CondTurn_2_Conductor_26_R, Slot_1_CondTurn_2_Conductor_61_L, Slot_1_CondTurn_2_Conductor_62_R, Slot_1_CondTurn_2_Conductor_23_L, Slot_1_CondTurn_3_Conductor_24_R, Slot_1_CondTurn_3_Conductor_60_R, Slot_1_CondTurn_3_Conductor_59_L, Slot_1_CondTurn_3_Conductor_21_L, Slot_1_CondTurn_3_Conductor_22_R, Slot_1_CondTurn_3_Conductor_57_L, Slot_1_CondTurn_3_Conductor_58_R, Slot_1_CondTurn_3_Conductor_20_R, Slot_1_CondTurn_4_Conductor_19_L, Slot_1_CondTurn_3_Conductor_90_L, Slot_1_CondTurn_3_Conductor_56_R, Slot_1_CondTurn_3_Conductor_55_L, Slot_1_CondTurn_3_Conductor_18_R, Slot_1_CondTurn_4_Conductor_17_L, Slot_1_CondTurn_3_Conductor_89_L, Slot_1_CondTurn_3_Conductor_54_R, Slot_1_CondTurn_4_Conductor_53_L, Slot_1_CondTurn_4_Conductor_15_L, Slot_1_CondTurn_3_Conductor_16_R, Slot_1_CondTurn_4_Conductor_88_L, Slot_1_CondTurn_4_Conductor_52_R, Slot_1_CondTurn_4_Conductor_51_L, Slot_1_CondTurn_4_Conductor_13_L, Slot_1_CondTurn_4_Conductor_14_R, Slot_1_CondTurn_4_Conductor_87_L, Slot_1_CondTurn_4_Conductor_50_R, Slot_1_CondTurn_4_Conductor_49_L, Slot_1_CondTurn_4_Conductor_11_L, Slot_1_CondTurn_5_Conductor_12_R, Slot_1_CondTurn_4_Conductor_86_L, Slot_1_CondTurn_5_Conductor_48_R, Slot_1_CondTurn_4_Conductor_47_L, Slot_1_CondTurn_6_Conductor_9_L, Slot_1_CondTurn_5_Conductor_10_R, Slot_1_CondTurn_5_Conductor_85_R, Slot_1_CondTurn_5_Conductor_84_L, Slot_1_CondTurn_5_Conductor_45_L, Slot_1_CondTurn_5_Conductor_46_R, Slot_1_CondTurn_5_Conductor_8_R, Slot_1_CondTurn_6_Conductor_7_L, Slot_1_CondTurn_5_Conductor_83_R, Slot_1_CondTurn_5_Conductor_82_L, Slot_1_CondTurn_6_Conductor_43_L, Slot_1_CondTurn_5_Conductor_44_R, Slot_1_CondTurn_5_Conductor_6_R, Slot_1_CondTurn_6_Conductor_5_L, Slot_1_CondTurn_6_Conductor_80_L, Slot_1_CondTurn_5_Conductor_81_R, Slot_1_CondTurn_6_Conductor_41_L, Slot_1_CondTurn_5_Conductor_42_R, Slot_1_CondTurn_6_Conductor_3_L, Slot_1_CondTurn_5_Conductor_4_R, Slot_1_CondTurn_6_Conductor_79_R, Slot_1_CondTurn_6_Conductor_78_L, Slot_1_CondTurn_6_Conductor_39_L, Slot_1_CondTurn_6_Conductor_40_R, Slot_1_CondTurn_6_Conductor_1_L, Slot_1_CondTurn_6_Conductor_2_R, Slot_1_CondTurn_6_Conductor_76_L, Slot_1_CondTurn_6_Conductor_77_R].rotate(axis=Z, angle=0deg)
  group Slot_1_Turn_1 = Slot_1_CondTurn_1_Conductor_75_L, Slot_1_CondTurn_1_Conductor_38_R, Slot_1_CondTurn_1_Conductor_37_L, Slot_1_CondTurn_1_Conductor_74_R, Slot_1_CondTurn_1_Conductor_73_L, Slot_1_CondTurn_1_Conductor_36_R, Slot_1_CondTurn_1_Conductor_35_L, Slot_1_CondTurn_1_Conductor_72_R, Slot_1_CondTurn_1_Conductor_71_L, Slot_1_CondTurn_1_Conductor_33_L, Slot_1_CondTurn_1_Conductor_34_R, Slot_1_CondTurn_1_Conductor_70_R, Slot_1_CondTurn_1_Conductor_69_L, Slot_1_CondTurn_1_Conductor_31_L, Slot_1_CondTurn_1_Conductor_32_R
  group Slot_1_Turn_2 = Slot_1_CondTurn_2_Conductor_67_L, Slot_1_CondTurn_2_Conductor_68_R, Slot_1_CondTurn_2_Conductor_29_L, Slot_1_CondTurn_2_Conductor_30_R, Slot_1_CondTurn_2_Conductor_66_R, Slot_1_CondTurn_2_Conductor_65_L, Slot_1_CondTurn_2_Conductor_27_L, Slot_1_CondTurn_2_Conductor_28_R, Slot_1_CondTurn_2_Conductor_63_L, Slot_1_CondTurn_2_Conductor_64_R, Slot_1_CondTurn_2_Conductor_25_L, Slot_1_CondTurn_2_Conductor_26_R, Slot_1_CondTurn_2_Conductor_61_L, Slot_1_CondTurn_2_Conductor_62_R, Slot_1_CondTurn_2_Conductor_23_L
  group Slot_1_Turn_3 = Slot_1_CondTurn_3_Conductor_24_R, Slot_1_CondTurn_3_Conductor_60_R, Slot_1_CondTurn_3_Conductor_59_L, Slot_1_CondTurn_3_Conductor_21_L, Slot_1_CondTurn_3_Conductor_22_R, Slot_1_CondTurn_3_Conductor_57_L, Slot_1_CondTurn_3_Conductor_58_R, Slot_1_CondTurn_3_Conductor_20_R, Slot_1_CondTurn_3_Conductor_90_L, Slot_1_CondTurn_3_Conductor_56_R, Slot_1_CondTurn_3_Conductor_55_L, Slot_1_CondTurn_3_Conductor_18_R, Slot_1_CondTurn_3_Conductor_89_L, Slot_1_CondTurn_3_Conductor_54_R, Slot_1_CondTurn_3_Conductor_16_R
  group Slot_1_Turn_4 = Slot_1_CondTurn_4_Conductor_19_L, Slot_1_CondTurn_4_Conductor_17_L, Slot_1_CondTurn_4_Conductor_53_L, Slot_1_CondTurn_4_Conductor_15_L, Slot_1_CondTurn_4_Conductor_88_L, Slot_1_CondTurn_4_Conductor_52_R, Slot_1_CondTurn_4_Conductor_51_L, Slot_1_CondTurn_4_Conductor_13_L, Slot_1_CondTurn_4_Conductor_14_R, Slot_1_CondTurn_4_Conductor_87_L, Slot_1_CondTurn_4_Conductor_50_R, Slot_1_CondTurn_4_Conductor_49_L, Slot_1_CondTurn_4_Conductor_11_L, Slot_1_CondTurn_4_Conductor_86_L, Slot_1_CondTurn_4_Conductor_47_L
  group Slot_1_Turn_5 = Slot_1_CondTurn_5_Conductor_12_R, Slot_1_CondTurn_5_Conductor_48_R, Slot_1_CondTurn_5_Conductor_10_R, Slot_1_CondTurn_5_Conductor_85_R, Slot_1_CondTurn_5_Conductor_84_L, Slot_1_CondTurn_5_Conductor_45_L, Slot_1_CondTurn_5_Conductor_46_R, Slot_1_CondTurn_5_Conductor_8_R, Slot_1_CondTurn_5_Conductor_83_R, Slot_1_CondTurn_5_Conductor_82_L, Slot_1_CondTurn_5_Conductor_44_R, Slot_1_CondTurn_5_Conductor_6_R, Slot_1_CondTurn_5_Conductor_81_R, Slot_1_CondTurn_5_Conductor_42_R, Slot_1_CondTurn_5_Conductor_4_R
  group Slot_1_Turn_6 = Slot_1_CondTurn_6_Conductor_9_L, Slot_1_CondTurn_6_Conductor_7_L, Slot_1_CondTurn_6_Conductor_43_L, Slot_1_CondTurn_6_Conductor_5_L, Slot_1_CondTurn_6_Conductor_80_L, Slot_1_CondTurn_6_Conductor_41_L, Slot_1_CondTurn_6_Conductor_3_L, Slot_1_CondTurn_6_Conductor_79_R, Slot_1_CondTurn_6_Conductor_78_L, Slot_1_CondTurn_6_Conductor_39_L, Slot_1_CondTurn_6_Conductor_40_R, Slot_1_CondTurn_6_Conductor_1_L, Slot_1_CondTurn_6_Conductor_2_R, Slot_1_CondTurn_6_Conductor_76_L, Slot_1_CondTurn_6_Conductor_77_R
motion:
  MotionSetup1: Band Move_Type=Rotate Coordinate_System=Global Axis=Z Is_Positive=true InitPos=InitialPositionMD Angular_Velocity=-MachineRPM Objects=Rotating_Band_out
  Moving1: Moving Objects=[Rotor_1, RotorAir, RotorDuctFluidRegion, Shaft, RotorDuctFluidRegion_1, RotorAir_1, Rotor_Pocket, Rotor_Pocket_1..Rotor_Pocket_4, L1_1Magnet2N1_1_1, L1_1Magnet3N1_1_1, Rotor_Pocket_5, L4_1Magnet2N1_1_1, L4_1Magnet3N1_1_1, Rotor_Pocket_6..Rotor_Pocket_9, Rotating_Band_mid, Rotating_Band_in]
boundaries and excitations:
  VectorPotential1: Vector Potential Edges=Whole_Region.edge(at (115.485, 47.8354, 0)) Value=0
  Independent1: Independent Objects=Boundary_Independent
  Dependent1: Dependent Objects=Boundary_Dependent Independent=Independent1 SameAsMaster=false
  CT_Ph1_P2_C1_Ret: Coil Objects=Ph1_P2_C1_2 Conductor_number=6 Winding=WG_Ph1 PolarityType=Negative
  CT_Ph2_P2_C1_Ret: Coil Objects=Ph2_P2_C1_1 Conductor_number=6 Winding=WG_Ph2 PolarityType=Negative
  CT_Ph2_P2_C2_Ret: Coil Objects=Ph2_P2_C2_2 Conductor_number=6 Winding=WG_Ph2 PolarityType=Negative
  CT_Ph3_P1_C1_Go: Coil Objects=Ph3_P1_C1_1 Conductor_number=6 Winding=WG_Ph3 PolarityType=Positive
  CT_Ph3_P1_C2_Go: Coil Objects=Ph3_P1_C2_2 Conductor_number=6 Winding=WG_Ph3 PolarityType=Positive
  L1_1Magnet2N1_1_1: Current Objects=L1_1Magnet2N1_1_1 Current=0A IsSolid=true IsPositive=true
  L1_1Magnet3N1_1_1: Current Objects=L1_1Magnet3N1_1_1 Current=0A IsSolid=true IsPositive=true
  L4_1Magnet2N1_1_1: Current Objects=L4_1Magnet2N1_1_1 Current=0A IsSolid=true IsPositive=true
  L4_1Magnet3N1_1_1: Current Objects=L4_1Magnet3N1_1_1 Current=0A IsSolid=true IsPositive=true
  Slot_1_CondTurn_1_Conductor_75_L_Pos: Coil Objects=Slot_1_CondTurn_1_Conductor_75_L Conductor_number=1 Winding=-1 PolarityType=Positive
  Slot_1_CondTurn_1_Conductor_38_R_Pos: Coil Objects=Slot_1_CondTurn_1_Conductor_38_R Conductor_number=1 Winding=-1 PolarityType=Positive
  Slot_1_CondTurn_1_Conductor_37_L_Pos: Coil Objects=Slot_1_CondTurn_1_Conductor_37_L Conductor_number=1 Winding=-1 PolarityType=Positive
  Slot_1_CondTurn_1_Conductor_74_R_Pos: Coil Objects=Slot_1_CondTurn_1_Conductor_74_R Conductor_number=1 Winding=-1 PolarityType=Positive
  Slot_1_CondTurn_1_Conductor_73_L_Pos: Coil Objects=Slot_1_CondTurn_1_Conductor_73_L Conductor_number=1 Winding=-1 PolarityType=Positive
  Slot_1_CondTurn_1_Conductor_36_R_Pos: Coil Objects=Slot_1_CondTurn_1_Conductor_36_R Conductor_number=1 Winding=-1 PolarityType=Positive
  Slot_1_CondTurn_1_Conductor_35_L_Pos: Coil Objects=Slot_1_CondTurn_1_Conductor_35_L Conductor_number=1 Winding=-1 PolarityType=Positive
  Slot_1_CondTurn_1_Conductor_72_R_Pos: Coil Objects=Slot_1_CondTurn_1_Conductor_72_R Conductor_number=1 Winding=-1 PolarityType=Positive
  Slot_1_CondTurn_1_Conductor_71_L_Pos: Coil Objects=Slot_1_CondTurn_1_Conductor_71_L Conductor_number=1 Winding=-1 PolarityType=Positive
  Slot_1_CondTurn_1_Conductor_33_L_Pos: Coil Objects=Slot_1_CondTurn_1_Conductor_33_L Conductor_number=1 Winding=-1 PolarityType=Positive
  Slot_1_CondTurn_1_Conductor_34_R_Pos: Coil Objects=Slot_1_CondTurn_1_Conductor_34_R Conductor_number=1 Winding=-1 PolarityType=Positive
  Slot_1_CondTurn_1_Conductor_70_R_Pos: Coil Objects=Slot_1_CondTurn_1_Conductor_70_R Conductor_number=1 Winding=-1 PolarityType=Positive
  Slot_1_CondTurn_1_Conductor_69_L_Pos: Coil Objects=Slot_1_CondTurn_1_Conductor_69_L Conductor_number=1 Winding=-1 PolarityType=Positive
  Slot_1_CondTurn_1_Conductor_31_L_Pos: Coil Objects=Slot_1_CondTurn_1_Conductor_31_L Conductor_number=1 Winding=-1 PolarityType=Positive
  Slot_1_CondTurn_1_Conductor_32_R_Pos: Coil Objects=Slot_1_CondTurn_1_Conductor_32_R Conductor_number=1 Winding=-1 PolarityType=Positive
  Slot_1_CondTurn_2_Conductor_67_L_Pos: Coil Objects=Slot_1_CondTurn_2_Conductor_67_L Conductor_number=1 Winding=-1 PolarityType=Positive
  Slot_1_CondTurn_2_Conductor_68_R_Pos: Coil Objects=Slot_1_CondTurn_2_Conductor_68_R Conductor_number=1 Winding=-1 PolarityType=Positive
  Slot_1_CondTurn_2_Conductor_29_L_Pos: Coil Objects=Slot_1_CondTurn_2_Conductor_29_L Conductor_number=1 Winding=-1 PolarityType=Positive
  Slot_1_CondTurn_2_Conductor_30_R_Pos: Coil Objects=Slot_1_CondTurn_2_Conductor_30_R Conductor_number=1 Winding=-1 PolarityType=Positive
  Slot_1_CondTurn_2_Conductor_66_R_Pos: Coil Objects=Slot_1_CondTurn_2_Conductor_66_R Conductor_number=1 Winding=-1 PolarityType=Positive
  Slot_1_CondTurn_2_Conductor_65_L_Pos: Coil Objects=Slot_1_CondTurn_2_Conductor_65_L Conductor_number=1 Winding=-1 PolarityType=Positive
  Slot_1_CondTurn_2_Conductor_27_L_Pos: Coil Objects=Slot_1_CondTurn_2_Conductor_27_L Conductor_number=1 Winding=-1 PolarityType=Positive
  Slot_1_CondTurn_2_Conductor_28_R_Pos: Coil Objects=Slot_1_CondTurn_2_Conductor_28_R Conductor_number=1 Winding=-1 PolarityType=Positive
  Slot_1_CondTurn_2_Conductor_63_L_Pos: Coil Objects=Slot_1_CondTurn_2_Conductor_63_L Conductor_number=1 Winding=-1 PolarityType=Positive
  Slot_1_CondTurn_2_Conductor_64_R_Pos: Coil Objects=Slot_1_CondTurn_2_Conductor_64_R Conductor_number=1 Winding=-1 PolarityType=Positive
  Slot_1_CondTurn_2_Conductor_25_L_Pos: Coil Objects=Slot_1_CondTurn_2_Conductor_25_L Conductor_number=1 Winding=-1 PolarityType=Positive
  Slot_1_CondTurn_2_Conductor_26_R_Pos: Coil Objects=Slot_1_CondTurn_2_Conductor_26_R Conductor_number=1 Winding=-1 PolarityType=Positive
  Slot_1_CondTurn_2_Conductor_61_L_Pos: Coil Objects=Slot_1_CondTurn_2_Conductor_61_L Conductor_number=1 Winding=-1 PolarityType=Positive
  Slot_1_CondTurn_2_Conductor_62_R_Pos: Coil Objects=Slot_1_CondTurn_2_Conductor_62_R Conductor_number=1 Winding=-1 PolarityType=Positive
  Slot_1_CondTurn_2_Conductor_23_L_Pos: Coil Objects=Slot_1_CondTurn_2_Conductor_23_L Conductor_number=1 Winding=-1 PolarityType=Positive
  Slot_1_CondTurn_3_Conductor_24_R_Pos: Coil Objects=Slot_1_CondTurn_3_Conductor_24_R Conductor_number=1 Winding=-1 PolarityType=Positive
  Slot_1_CondTurn_3_Conductor_60_R_Pos: Coil Objects=Slot_1_CondTurn_3_Conductor_60_R Conductor_number=1 Winding=-1 PolarityType=Positive
  Slot_1_CondTurn_3_Conductor_59_L_Pos: Coil Objects=Slot_1_CondTurn_3_Conductor_59_L Conductor_number=1 Winding=-1 PolarityType=Positive
  Slot_1_CondTurn_3_Conductor_21_L_Pos: Coil Objects=Slot_1_CondTurn_3_Conductor_21_L Conductor_number=1 Winding=-1 PolarityType=Positive
  Slot_1_CondTurn_3_Conductor_22_R_Pos: Coil Objects=Slot_1_CondTurn_3_Conductor_22_R Conductor_number=1 Winding=-1 PolarityType=Positive
  Slot_1_CondTurn_3_Conductor_57_L_Pos: Coil Objects=Slot_1_CondTurn_3_Conductor_57_L Conductor_number=1 Winding=-1 PolarityType=Positive
  Slot_1_CondTurn_3_Conductor_58_R_Pos: Coil Objects=Slot_1_CondTurn_3_Conductor_58_R Conductor_number=1 Winding=-1 PolarityType=Positive
  Slot_1_CondTurn_3_Conductor_20_R_Pos: Coil Objects=Slot_1_CondTurn_3_Conductor_20_R Conductor_number=1 Winding=-1 PolarityType=Positive
  Slot_1_CondTurn_4_Conductor_19_L_Pos: Coil Objects=Slot_1_CondTurn_4_Conductor_19_L Conductor_number=1 Winding=-1 PolarityType=Positive
  Slot_1_CondTurn_3_Conductor_90_L_Pos: Coil Objects=Slot_1_CondTurn_3_Conductor_90_L Conductor_number=1 Winding=-1 PolarityType=Positive
  Slot_1_CondTurn_3_Conductor_56_R_Pos: Coil Objects=Slot_1_CondTurn_3_Conductor_56_R Conductor_number=1 Winding=-1 PolarityType=Positive
  Slot_1_CondTurn_3_Conductor_55_L_Pos: Coil Objects=Slot_1_CondTurn_3_Conductor_55_L Conductor_number=1 Winding=-1 PolarityType=Positive
  Slot_1_CondTurn_3_Conductor_18_R_Pos: Coil Objects=Slot_1_CondTurn_3_Conductor_18_R Conductor_number=1 Winding=-1 PolarityType=Positive
  Slot_1_CondTurn_4_Conductor_17_L_Pos: Coil Objects=Slot_1_CondTurn_4_Conductor_17_L Conductor_number=1 Winding=-1 PolarityType=Positive
  Slot_1_CondTurn_3_Conductor_89_L_Pos: Coil Objects=Slot_1_CondTurn_3_Conductor_89_L Conductor_number=1 Winding=-1 PolarityType=Positive
  Slot_1_CondTurn_3_Conductor_54_R_Pos: Coil Objects=Slot_1_CondTurn_3_Conductor_54_R Conductor_number=1 Winding=-1 PolarityType=Positive
  Slot_1_CondTurn_4_Conductor_53_L_Pos: Coil Objects=Slot_1_CondTurn_4_Conductor_53_L Conductor_number=1 Winding=-1 PolarityType=Positive
  Slot_1_CondTurn_4_Conductor_15_L_Pos: Coil Objects=Slot_1_CondTurn_4_Conductor_15_L Conductor_number=1 Winding=-1 PolarityType=Positive
  Slot_1_CondTurn_3_Conductor_16_R_Pos: Coil Objects=Slot_1_CondTurn_3_Conductor_16_R Conductor_number=1 Winding=-1 PolarityType=Positive
  Slot_1_CondTurn_4_Conductor_88_L_Pos: Coil Objects=Slot_1_CondTurn_4_Conductor_88_L Conductor_number=1 Winding=-1 PolarityType=Positive
  Slot_1_CondTurn_4_Conductor_52_R_Pos: Coil Objects=Slot_1_CondTurn_4_Conductor_52_R Conductor_number=1 Winding=-1 PolarityType=Positive
  Slot_1_CondTurn_4_Conductor_51_L_Pos: Coil Objects=Slot_1_CondTurn_4_Conductor_51_L Conductor_number=1 Winding=-1 PolarityType=Positive
  Slot_1_CondTurn_4_Conductor_13_L_Pos: Coil Objects=Slot_1_CondTurn_4_Conductor_13_L Conductor_number=1 Winding=-1 PolarityType=Positive
  Slot_1_CondTurn_4_Conductor_14_R_Pos: Coil Objects=Slot_1_CondTurn_4_Conductor_14_R Conductor_number=1 Winding=-1 PolarityType=Positive
  Slot_1_CondTurn_4_Conductor_87_L_Pos: Coil Objects=Slot_1_CondTurn_4_Conductor_87_L Conductor_number=1 Winding=-1 PolarityType=Positive
  Slot_1_CondTurn_4_Conductor_50_R_Pos: Coil Objects=Slot_1_CondTurn_4_Conductor_50_R Conductor_number=1 Winding=-1 PolarityType=Positive
  Slot_1_CondTurn_4_Conductor_49_L_Pos: Coil Objects=Slot_1_CondTurn_4_Conductor_49_L Conductor_number=1 Winding=-1 PolarityType=Positive
  Slot_1_CondTurn_4_Conductor_11_L_Pos: Coil Objects=Slot_1_CondTurn_4_Conductor_11_L Conductor_number=1 Winding=-1 PolarityType=Positive
  Slot_1_CondTurn_5_Conductor_12_R_Pos: Coil Objects=Slot_1_CondTurn_5_Conductor_12_R Conductor_number=1 Winding=-1 PolarityType=Positive
  Slot_1_CondTurn_4_Conductor_86_L_Pos: Coil Objects=Slot_1_CondTurn_4_Conductor_86_L Conductor_number=1 Winding=-1 PolarityType=Positive
  Slot_1_CondTurn_5_Conductor_48_R_Pos: Coil Objects=Slot_1_CondTurn_5_Conductor_48_R Conductor_number=1 Winding=-1 PolarityType=Positive
  Slot_1_CondTurn_4_Conductor_47_L_Pos: Coil Objects=Slot_1_CondTurn_4_Conductor_47_L Conductor_number=1 Winding=-1 PolarityType=Positive
  Slot_1_CondTurn_6_Conductor_9_L_Pos: Coil Objects=Slot_1_CondTurn_6_Conductor_9_L Conductor_number=1 Winding=-1 PolarityType=Positive
  Slot_1_CondTurn_5_Conductor_10_R_Pos: Coil Objects=Slot_1_CondTurn_5_Conductor_10_R Conductor_number=1 Winding=-1 PolarityType=Positive
  Slot_1_CondTurn_5_Conductor_85_R_Pos: Coil Objects=Slot_1_CondTurn_5_Conductor_85_R Conductor_number=1 Winding=-1 PolarityType=Positive
  Slot_1_CondTurn_5_Conductor_84_L_Pos: Coil Objects=Slot_1_CondTurn_5_Conductor_84_L Conductor_number=1 Winding=-1 PolarityType=Positive
  Slot_1_CondTurn_5_Conductor_45_L_Pos: Coil Objects=Slot_1_CondTurn_5_Conductor_45_L Conductor_number=1 Winding=-1 PolarityType=Positive
  Slot_1_CondTurn_5_Conductor_46_R_Pos: Coil Objects=Slot_1_CondTurn_5_Conductor_46_R Conductor_number=1 Winding=-1 PolarityType=Positive
  Slot_1_CondTurn_5_Conductor_8_R_Pos: Coil Objects=Slot_1_CondTurn_5_Conductor_8_R Conductor_number=1 Winding=-1 PolarityType=Positive
  Slot_1_CondTurn_6_Conductor_7_L_Pos: Coil Objects=Slot_1_CondTurn_6_Conductor_7_L Conductor_number=1 Winding=-1 PolarityType=Positive
  Slot_1_CondTurn_5_Conductor_83_R_Pos: Coil Objects=Slot_1_CondTurn_5_Conductor_83_R Conductor_number=1 Winding=-1 PolarityType=Positive
  Slot_1_CondTurn_5_Conductor_82_L_Pos: Coil Objects=Slot_1_CondTurn_5_Conductor_82_L Conductor_number=1 Winding=-1 PolarityType=Positive
  Slot_1_CondTurn_6_Conductor_43_L_Pos: Coil Objects=Slot_1_CondTurn_6_Conductor_43_L Conductor_number=1 Winding=-1 PolarityType=Positive
  Slot_1_CondTurn_5_Conductor_44_R_Pos: Coil Objects=Slot_1_CondTurn_5_Conductor_44_R Conductor_number=1 Winding=-1 PolarityType=Positive
  Slot_1_CondTurn_5_Conductor_6_R_Pos: Coil Objects=Slot_1_CondTurn_5_Conductor_6_R Conductor_number=1 Winding=-1 PolarityType=Positive
  Slot_1_CondTurn_6_Conductor_5_L_Pos: Coil Objects=Slot_1_CondTurn_6_Conductor_5_L Conductor_number=1 Winding=-1 PolarityType=Positive
  Slot_1_CondTurn_6_Conductor_80_L_Pos: Coil Objects=Slot_1_CondTurn_6_Conductor_80_L Conductor_number=1 Winding=-1 PolarityType=Positive
  Slot_1_CondTurn_5_Conductor_81_R_Pos: Coil Objects=Slot_1_CondTurn_5_Conductor_81_R Conductor_number=1 Winding=-1 PolarityType=Positive
  Slot_1_CondTurn_6_Conductor_41_L_Pos: Coil Objects=Slot_1_CondTurn_6_Conductor_41_L Conductor_number=1 Winding=-1 PolarityType=Positive
  Slot_1_CondTurn_5_Conductor_42_R_Pos: Coil Objects=Slot_1_CondTurn_5_Conductor_42_R Conductor_number=1 Winding=-1 PolarityType=Positive
  Slot_1_CondTurn_6_Conductor_3_L_Pos: Coil Objects=Slot_1_CondTurn_6_Conductor_3_L Conductor_number=1 Winding=-1 PolarityType=Positive
  Slot_1_CondTurn_5_Conductor_4_R_Pos: Coil Objects=Slot_1_CondTurn_5_Conductor_4_R Conductor_number=1 Winding=-1 PolarityType=Positive
  Slot_1_CondTurn_6_Conductor_79_R_Pos: Coil Objects=Slot_1_CondTurn_6_Conductor_79_R Conductor_number=1 Winding=-1 PolarityType=Positive
  Slot_1_CondTurn_6_Conductor_78_L_Pos: Coil Objects=Slot_1_CondTurn_6_Conductor_78_L Conductor_number=1 Winding=-1 PolarityType=Positive
  Slot_1_CondTurn_6_Conductor_39_L_Pos: Coil Objects=Slot_1_CondTurn_6_Conductor_39_L Conductor_number=1 Winding=-1 PolarityType=Positive
  Slot_1_CondTurn_6_Conductor_40_R_Pos: Coil Objects=Slot_1_CondTurn_6_Conductor_40_R Conductor_number=1 Winding=-1 PolarityType=Positive
  Slot_1_CondTurn_6_Conductor_1_L_Pos: Coil Objects=Slot_1_CondTurn_6_Conductor_1_L Conductor_number=1 Winding=-1 PolarityType=Positive
  Slot_1_CondTurn_6_Conductor_2_R_Pos: Coil Objects=Slot_1_CondTurn_6_Conductor_2_R Conductor_number=1 Winding=-1 PolarityType=Positive
  Slot_1_CondTurn_6_Conductor_76_L_Pos: Coil Objects=Slot_1_CondTurn_6_Conductor_76_L Conductor_number=1 Winding=-1 PolarityType=Positive
  Slot_1_CondTurn_6_Conductor_77_R_Pos: Coil Objects=Slot_1_CondTurn_6_Conductor_77_R Conductor_number=1 Winding=-1 PolarityType=Positive
  WG_Ph1: Winding Group Type=Current IsSolid=false Current="IPeak * sin((pi * MachineRPM/1rpm*NumPoles / 60*time + (360 - 0) / 360 * 2 * pi) + PhaseAdvance )" ParallelBranchesNum=ParallelPaths
  WG_Ph2: Winding Group Type=Current IsSolid=false Current="IPeak * sin((pi * MachineRPM/1rpm*NumPoles / 60*time + (360 - 120) / 360 * 2 * pi) + PhaseAdvance )" ParallelBranchesNum=ParallelPaths
  WG_Ph3: Winding Group Type=Current IsSolid=false Current="IPeak * sin((pi * MachineRPM/1rpm*NumPoles / 60*time + (360 - 240) / 360 * 2 * pi) + PhaseAdvance )" ParallelBranchesNum=ParallelPaths
  eddy effects on: L1_1Magnet2N1_1_1, L1_1Magnet3N1_1_1, L4_1Magnet2N1_1_1, L4_1Magnet3N1_1_1
  core loss on: Stator, Rotor_1
mesh:
  CylindricalGap1: CylindricalGap Objects=Rotating_Band_out
  initial mesh: MeshMethod=AnsoftTAU
temperatures:
  Rotor_1, RotorAir, RotorDuctFluidRegion, Shaft, RotorDuctFluidRegion_1, RotorAir_1, Rotor_Pocket, Rotor_Pocket_1..Rotor_Pocket_7, Stator, Rotor_Pocket_8, Rotor_Pocket_9, Rotating_Band_mid, Rotating_Band_in, Rotating_Band_out, Ph2_P2_C1_1, Ph3_P1_C1_1, Ph1_P2_C1_2, Ph2_P2_C2_2, Ph3_P1_C2_2, Whole_Region, Boundary_Independent, Boundary_Dependent, Slot_1_CondTurn_1_Conductor_75_L, Slot_1_CondTurn_1_Conductor_38_R, Slot_1_CondTurn_1_Conductor_37_L, Slot_1_CondTurn_1_Conductor_74_R, Slot_1_CondTurn_1_Conductor_73_L, Slot_1_CondTurn_1_Conductor_36_R, Slot_1_CondTurn_1_Conductor_35_L, Slot_1_CondTurn_1_Conductor_72_R, Slot_1_CondTurn_1_Conductor_71_L, Slot_1_CondTurn_1_Conductor_33_L, Slot_1_CondTurn_1_Conductor_34_R, Slot_1_CondTurn_1_Conductor_70_R, Slot_1_CondTurn_1_Conductor_69_L, Slot_1_CondTurn_1_Conductor_31_L, Slot_1_CondTurn_1_Conductor_32_R, Slot_1_CondTurn_2_Conductor_67_L, Slot_1_CondTurn_2_Conductor_68_R, Slot_1_CondTurn_2_Conductor_29_L, Slot_1_CondTurn_2_Conductor_30_R, Slot_1_CondTurn_2_Conductor_66_R, Slot_1_CondTurn_2_Conductor_65_L, Slot_1_CondTurn_2_Conductor_27_L, Slot_1_CondTurn_2_Conductor_28_R, Slot_1_CondTurn_2_Conductor_63_L, Slot_1_CondTurn_2_Conductor_64_R, Slot_1_CondTurn_2_Conductor_25_L, Slot_1_CondTurn_2_Conductor_26_R, Slot_1_CondTurn_2_Conductor_61_L, Slot_1_CondTurn_2_Conductor_62_R, Slot_1_CondTurn_2_Conductor_23_L, Slot_1_CondTurn_3_Conductor_24_R, Slot_1_CondTurn_3_Conductor_60_R, Slot_1_CondTurn_3_Conductor_59_L, Slot_1_CondTurn_3_Conductor_21_L, Slot_1_CondTurn_3_Conductor_22_R, Slot_1_CondTurn_3_Conductor_57_L, Slot_1_CondTurn_3_Conductor_58_R, Slot_1_CondTurn_3_Conductor_20_R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: 22cel
  L1_1Magnet2N1_1_1, L1_1Magnet3N1_1_1, L4_1Magnet2N1_1_1, L4_1Magnet3N1_1_1: 20cel
setups:
  Setup1: Transient NonlinearSolverResidual=0.0001 StopTime="NumTorqueCycles*120/(MachineRPM/1rpm*NumPoles) s" TimeStep="120/(MachineRPM/1rpm*NumPoles)/NumTorquePointsPerCycle s" OutputPerObjectCoreLoss OutputPerObjectSolidLoss SaveFieldsType=Custom SweepRanges{0ns to 0.0025s step 8.3333333e-05s} NumberSolveSteps=1 RangeStart=0s RangeEnd=0.1s InitialTimeStep="120/(MachineRPM/1rpm*NumPoles)/NumTorquePointsPerCycle s" MinTimeStep=0.001s MaxTimeStep=0.003s TimeStepErrTolerance=0.0001
output variables:
  ThetaED = ((pi * MachineRPM/1rpm*NumPoles / 60*time + (360 - 0) / 360 * 2 * pi)) + pi
  Id_peak = 2/3*(InputCurrent(WG_Ph1)*cos(ThetaED+360deg)+InputCurrent(WG_Ph2)*cos(ThetaED+240deg)+InputCurrent(WG_Ph3)*cos(ThetaED+120deg))
  Iq_peak = 2/3*(InputCurrent(WG_Ph1)*-sin(ThetaED+360deg)+InputCurrent(WG_Ph2)*-sin(ThetaED+240deg)+InputCurrent(WG_Ph3)*-sin(ThetaED+120deg))
  PsiD = 2/3*(FluxLinkage(WG_Ph1)*cos(ThetaED+360deg)+FluxLinkage(WG_Ph2)*cos(ThetaED+240deg)+FluxLinkage(WG_Ph3)*cos(ThetaED+120deg))
  PsiQ = 2/3*(FluxLinkage(WG_Ph1)*-sin(ThetaED+360deg)+FluxLinkage(WG_Ph2)*-sin(ThetaED+240deg)+FluxLinkage(WG_Ph3)*-sin(ThetaED+120deg))
  TorqueDQ = 3/2*NumPoles/2*(PsiD*Iq_peak - PsiQ*Id_peak)
reports:
  Induced Voltage Plots: InducedVoltage(WG_Ph1), InducedVoltage(WG_Ph2), InducedVoltage(WG_Ph3) vs Time on Setup1 : Transient
  Drive Current Plots: InputCurrent(WG_Ph1), InputCurrent(WG_Ph2), InputCurrent(WG_Ph3), Id_peak, Iq_peak vs Time on Setup1 : Transient
  Flux Linkage Plots: FluxLinkage(WG_Ph1), FluxLinkage(WG_Ph2), FluxLinkage(WG_Ph3), PsiD, PsiQ vs Time on Setup1 : Transient
  Torque Plots: -Moving1.Torque, TorqueDQ vs Time on Setup1 : Transient; -Moving1.Torque vs Time
